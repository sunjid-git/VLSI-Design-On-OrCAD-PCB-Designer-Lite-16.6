** Profile: "SCHEMATIC1-Nmos"  [ E:\VLSI DESIGN LAB 1\NMOS\NMos-PSpiceFiles\SCHEMATIC1\Nmos.sim ]

** Creating circuit file "Nmos.cir"
** WARNING: THIS AUTOMATICALLY GENERATED FILE MAY BE OVERWRITTEN BY SUBSEQUENT SIMULATIONS

*Libraries:
* Profile Libraries :
* Local Libraries :
* From [PSPICE NETLIST] section of C:\SPB_Data\cdssetup\OrCAD_PSpice/16.6.0/PSpice.ini file:
.lib "nomd.lib"

*Analysis directives:
.DC LIN V_V1 0 15 .5
+ LIN V_V2 0 5 1
.OPTIONS ADVCONV
.PROBE64 V(alias(*)) I(alias(*)) W(alias(*)) D(alias(*)) NOISE(alias(*))
.INC "..\SCHEMATIC1.net"

.END
